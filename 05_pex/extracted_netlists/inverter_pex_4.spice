* SPICE3 file created from inverter_schematic.ext - technology: sky130A

X0 XM1/S.t0 XM1/G.t0 XM1/D.t0 XM1/B.t0 sky130_fd_pr__nfet_01v8 ad=0.29 pd=2.58 as=0.29 ps=2.58 w=1 l=0.15
X1 XM2/S.t0 XM2/G.t0 XM2/D.t0 XM2/B.t0 sky130_fd_pr__pfet_01v8 ad=0.58 pd=4.58 as=0.58 ps=4.58 w=2 l=0.15
C0 vdd vin 0.79714f
C1 vdd vout 0.7316f
C2 vin vout 0.34195f
R0 gnd XM1/S.n0 61.6672
R1 XM1/S.n0 XM1/S.t0 17.4005
R2 vout XM1/D.n0 61.6672
R3 XM1/D.n0 XM1/D.t0 17.4005
R4 XM1/G.n0 XM1/G.t0 220.113
R5 vin XM1/G.n0 152
R6 XM1/B.n8 XM1/B.n2 2306.06
R7 XM1/B.n5 XM1/B.n3 2306.06
R8 XM1/B.n6 XM1/B.n2 744.25
R9 XM1/B.n7 XM1/B.n3 744.25
R10 XM1/B.n5 XM1/B.n4 292.5
R11 gnd XM1/B.n8 292.5
R12 XM1/B.n6 XM1/B.n5 175.803
R13 XM1/B.n8 XM1/B.n7 175.803
R14 XM1/B.n4 XM1/B.n0 149.835
R15 XM1/B.n4 XM1/B.n1 149.835
R16 gnd XM1/B.n1 149.835
R17 gnd XM1/B.n0 149.835
R18 XM1/B.n2 XM1/B.n0 117.001
R19 XM1/B.n3 XM1/B.n1 117.001
R20 XM1/B.n7 XM1/B.t0 94.4014
R21 XM1/B.t0 XM1/B.n6 94.4014
R22 vdd XM2/S.n0 97.5005
R23 XM2/S.n0 XM2/S.t0 14.283
R24 vout XM2/D.n0 97.5005
R25 XM2/D.n0 XM2/D.t0 14.283
R26 XM2/G.n0 XM2/G.t0 395.24
R27 vin XM2/G.n0 152
R28 XM2/B.n8 XM2/B.n2 1789.41
R29 XM2/B.n5 XM2/B.n3 1789.41
R30 XM2/B.n4 XM2/B.n0 190.871
R31 XM2/B.n4 XM2/B.n1 190.871
R32 vdd XM2/B.n1 190.871
R33 vdd XM2/B.n0 190.871
R34 XM2/B.n6 XM2/B.n2 173.642
R35 XM2/B.n7 XM2/B.n3 173.642
R36 XM2/B.n5 XM2/B.n4 92.5005
R37 vdd XM2/B.n8 92.5005
R38 XM2/B.n6 XM2/B.n5 79.4196
R39 XM2/B.n8 XM2/B.n7 79.4196
R40 XM2/B.n2 XM2/B.n0 23.1255
R41 XM2/B.n3 XM2/B.n1 23.1255
R42 XM2/B.n7 XM2/B.t0 8.97701
R43 XM2/B.t0 XM2/B.n6 8.97701
R44 vin.n4 vin.n3 561.047
R45 vin vin.n4 547.24
R46 vin.n1 vin.n0 186.179
R47 vin vin.n3 14.653
R48 vin.n2 vin.n1 7.22109
R49 vin.n1 vin 6.65286
R50 vin.n2 vin 5.188
R51 vin.n3 vin.n2 0.46925
R52 vdd.n9 vdd.n3 1789.41
R53 vdd.n6 vdd.n3 1789.41
R54 vdd.n6 vdd.n4 1789.41
R55 vdd.n8 vdd.n4 339.003
R56 vdd.n7 vdd.n5 331.144
R57 vdd vdd.n0 190.871
R58 vdd.n10 vdd 190.871
R59 vdd.n5 vdd.n1 159.653
R60 vdd.n11 vdd.n10 132.775
R61 vdd.n14 vdd.n0 131.388
R62 vdd.n4 vdd 92.5005
R63 vdd.n3 vdd.n2 92.5005
R64 vdd.n5 vdd.n3 92.5005
R65 vdd.n6 vdd.n0 23.1255
R66 vdd.n7 vdd.n6 23.1255
R67 vdd.n10 vdd.n9 23.1255
R68 vdd.n9 vdd.n8 18.5058
R69 vdd.n15 vdd.n14 5.05427
R70 vdd.n13 vdd.n12 4.6505
R71 vdd.n8 vdd.n7 4.38202
R72 vdd vdd.n15 4.33135
R73 vdd.n11 vdd.n2 3.91881
R74 vdd.n14 vdd.n13 3.85932
R75 vdd.n13 vdd.n1 3.05932
R76 vdd.n12 vdd.n11 1.26515
R77 vdd.n2 vdd.n1 0.518147
R78 vdd.n15 vdd 0.0637415
R79 vdd.n12 vdd 0.0145625
R80 gnd.n11 gnd.n2 2306.06
R81 gnd.n15 gnd.n3 2306.06
R82 gnd.n15 gnd.n2 2306.06
R83 gnd.n14 gnd.n13 1076.95
R84 gnd.n12 gnd.n11 832.705
R85 gnd.n14 gnd.n0 703.763
R86 gnd.n11 gnd.n10 292.5
R87 gnd gnd.n15 292.5
R88 gnd.n15 gnd.n14 292.5
R89 gnd.n10 gnd.n4 149.835
R90 gnd.n10 gnd.n9 149.835
R91 gnd.n4 gnd.n2 117.001
R92 gnd.n13 gnd.n2 117.001
R93 gnd.n9 gnd.n3 117.001
R94 gnd.n5 gnd.n4 91.8632
R95 gnd.n9 gnd.n8 90.3534
R96 gnd.n12 gnd.n3 71.1435
R97 gnd.n13 gnd.n12 42.249
R98 gnd.n7 gnd 6.74925
R99 gnd.n8 gnd.n1 5.31013
R100 gnd.n6 gnd.n1 4.6505
R101 gnd.n5 gnd.n0 4.22182
R102 gnd.n8 gnd.n7 4.04539
R103 gnd gnd.n1 2.18124
R104 gnd.n6 gnd.n5 2.06919
R105 gnd gnd.n0 0.901241
R106 gnd.n7 gnd 0.062128
R107 gnd gnd.n6 0.0281042
C3 vdd.n1 gnd 0.02954f
C4 vdd.n4 gnd 0.07424f
C5 vdd.n5 gnd 0.10354f
C6 vdd.n7 gnd 0.15372f
C7 vdd.n11 gnd 0.02619f
C8 vdd.n12 gnd 0.06688f
C9 vdd.n14 gnd 0.01502f
C10 vdd.n15 gnd 0.05494f
C11 vin.n0 gnd 0.01653f
C12 vin.n2 gnd 0.18956f
C13 vin.n3 gnd 0.13049f
C14 vin.n4 gnd 0.02094f
C15 vdd gnd 4.06141f
C16 XM2/B.n0 gnd 0.02158f
C17 XM2/B.n1 gnd 0.02158f
C18 XM2/B.n2 gnd 0.14171f
C19 XM2/B.n3 gnd 0.14171f
C20 XM2/B.n4 gnd 0.02211f
C21 XM2/B.n5 gnd 0.02211f
C22 XM2/B.t0 gnd 0.19338f
C23 XM2/B.n8 gnd 0.02211f
C24 XM2/G.t0 gnd 0.23782f
C25 XM2/G.n0 gnd 0.12283f
C26 XM2/D.t0 gnd 0.17138f
C27 XM2/D.n0 gnd 0.51413f
C28 XM2/S.t0 gnd 0.17138f
C29 XM2/S.n0 gnd 0.51413f
C30 vout gnd 0.87792f
C31 vin gnd 1.38237f
C32 XM1/G.t0 gnd 0.04301f
C33 XM1/G.n0 gnd 0.0259f
C34 XM1/D.t0 gnd 0.06145f
C35 XM1/D.n0 gnd 0.18434f
C36 XM1/S.t0 gnd 0.06145f
C37 XM1/S.n0 gnd 0.18434f
