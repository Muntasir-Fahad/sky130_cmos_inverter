** Transient temp sweep template
XM1 vout vin 0 0 sky130_fd_pr__nfet_01v8 L=0.15 W=1 nf=1 ad=0.29 as=0.29 pd=2.58 ps=2.58 nrd=0.29 nrs=0.29 sa=0 sb=0 sd=0 mult=1
XM2 vout vin vdd vdd sky130_fd_pr__pfet_01v8 L=0.15 W=2 nf=1 ad=0.58 as=0.58 pd=4.58 ps=4.58 nrd=0.145 nrs=0.145 sa=0 sb=0 sd=0 mult=1
V1 vdd 0 DC 1.8
V2 vin 0 PULSE(0 1.8 1n 10p 10p 5n 10n)
C1 vout 0 10f

.lib /usr/local/share/pdk/sky130A/libs.tech/combined/sky130.lib.spice tt

.temp TEMP_PLACEHOLDER

.control
tran 1p 20n
meas tran tphl trig v(vin) val=0.9 rise=1 targ v(vout) val=0.9 fall=1
meas tran tplh trig v(vin) val=0.9 fall=1 targ v(vout) val=0.9 rise=1
meas tran trise trig v(vout) val=0.18 rise=1 targ v(vout) val=1.62 rise=1
meas tran tfall trig v(vout) val=1.62 fall=1 targ v(vout) val=0.18 fall=1
.endc
.end
