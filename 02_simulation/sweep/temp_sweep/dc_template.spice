** DC temp sweep template
XM1 vout vin 0 0 sky130_fd_pr__nfet_01v8 L=0.15 W=1 nf=1 ad=0.29 as=0.29 pd=2.58 ps=2.58 nrd=0.29 nrs=0.29 sa=0 sb=0 sd=0 mult=1
XM2 vout vin vdd vdd sky130_fd_pr__pfet_01v8 L=0.15 W=2 nf=1 ad=0.58 as=0.58 pd=4.58 ps=4.58 nrd=0.145 nrs=0.145 sa=0 sb=0 sd=0 mult=1
V1 vdd 0 DC 1.8
V2 vin 0 DC 0
C1 vout 0 10f

.lib /usr/local/share/pdk/sky130A/libs.tech/combined/sky130.lib.spice tt

.temp TEMP_PLACEHOLDER

.control
dc V2 0 1.8 0.01
meas dc vm when v(vout)=0.9
let gain = deriv(v(vout))
let gain_abs = abs(gain)
meas dc gain_max max gain_abs
meas dc vil when gain=-1 from=0 to=0.9
meas dc vih when gain=-1 from=0.9 to=1.8
print nmh nml
.endc
.end
